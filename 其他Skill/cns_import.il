/****************************************************/
/*               Title :  CNS Import			    */
/*     Execute Command :  cns_import			    */
/*              Author :  Vivien Luo                */
/*       Creation Date :  2015-11-10                */
/*       		Update :                            */
/*              E-mail :  admin@allegro-skill.com	*/
/****************************************************/

axlCmdRegister("cns_import" 'cns_import_main)

defun(cns_import_main ()
let((form)
	CNSImportForm("1.3")
	form = axlFormCreate(gensym() "./cns_import.form" nil 'CNSImportFormAction t)
	CmgrImportFormInit(form)
	axlFormDisplay(form)
)
);end defun

defun(CmgrImportFormInit (form)
axlFormSetField(form "Default_P" t)
axlFormSetField(form "POWER" t)
axlFormSetField(form "Default_S" t)
axlFormSetField(form "BGA1_0_S" t)
axlFormSetField(form "BGA0_8_S" t)
axlFormSetField(form "15MILS" t)
axlFormColorize(form "Ver" 'text 'red)
)

defun(CNSImportFormAction (form)
case(form->curField
	("Import"
		when(axlFormGetField(form "Default_P")
			CNSImportPhysical("DEFAULT")
		)
		when(axlFormGetField(form "BGA1_0_P")
			CNSImportPhysical("BGA-1.0MM")
		)
		when(axlFormGetField(form "BGA0_8_P")
			CNSImportPhysical("BGA-0.8MM")
		)
		when(axlFormGetField(form "POWER")
			CNSImportPhysical("POWER")
		)
		when(axlFormGetField(form "Default_S")
			CNSImportSpacing("DEFAULT")
		)
		when(axlFormGetField(form "BGA1_0_S")
			CNSImportSpacing("BGA-1.0MM")
		)
		when(axlFormGetField(form "BGA0_8_S")
			CNSImportSpacing("BGA-0.8MM")
		)
		when(axlFormGetField(form "20MILS")
			CNSImportSpacing("20MILS")
		)
		when(axlFormGetField(form "15MILS")
			CNSImportSpacing("15MILS")
		)
		axlUIConfirm("Import complet......")
	)
	("About"
		CNSImportHelp()
	)
	("Exit"
		axlFormClose(form)
	)
);end case
);end defun

defun(CNSImportPhysical (cset)
let((Default BGA1_0 BGA0_8 POWER)
	Default ='((allow_padconnect NOT_ALLOWED)
	    (allow_ts ANYWHERE)
	    (allow_etch t)
	    (bbvia_stagger_max 0.0)
	    (bbvia_stagger_min 5.0)
	    (vias "VIA10-GEN:")
;	    (dp_coupled_minus 0.0) ;This three constraint are not supported in version 16.3
;	    (dp_coupled_plus 0.0)
;	    (dp_min_gap 0.0)
	    (dp_neck_gap 0.0)
	    (dp_primary_gap 0.0)
	    (necklength_max 200.0)
	    (neckwidth_min 5.0)
	    (width_max 0.0)
	    (width_min 6.0)
	)
	BGA1_0 = '((allow_padconnect NOT_ALLOWED)
	    (allow_ts ANYWHERE)
	    (allow_etch t)
	    (bbvia_stagger_max 0.0)
	    (bbvia_stagger_min 5.0)
	    (vias "VIA8-BGA-FULL:")
;	    (dp_coupled_minus 0.0) ;This three constraint are not supported in version 16.3
;	    (dp_coupled_plus 0.0)
;	    (dp_min_gap 0.0)
	    (dp_neck_gap 0.0)
	    (dp_primary_gap 0.0)
	    (necklength_max 200.0)
	    (neckwidth_min 5.0)
	    (width_max 0.0)
	    (width_min 6.0)
	)
	BGA0_8 = '((allow_padconnect NOT_ALLOWED)
	    (allow_ts ANYWHERE)
	    (allow_etch t)
	    (bbvia_stagger_max 0.0)
	    (bbvia_stagger_min 5.0)
	    (vias "VIA8-BGA-FULL:")
;	    (dp_coupled_minus 0.0) ;This three constraint are not supported in version 16.3
;	    (dp_coupled_plus 0.0)
;	    (dp_min_gap 0.0)
	    (dp_neck_gap 0.0)
	    (dp_primary_gap 0.0)
	    (necklength_max 200.0)
	    (neckwidth_min 4.0)
	    (width_max 0.0)
	    (width_min 4.0)
	)
	POWER = '((allow_padconnect NOT_ALLOWED)
	    (allow_ts ANYWHERE)
	    (allow_etch t)
	    (bbvia_stagger_max 0.0)
	    (bbvia_stagger_min 5.0)
	    (vias "VIA10-GEN:")
;	    (dp_coupled_minus 0.0) ;This three constraint are not supported in version 16.3
;	    (dp_coupled_plus 0.0)
;	    (dp_min_gap 0.0)
	    (dp_neck_gap 0.0)
	    (dp_primary_gap 0.0)
	    (necklength_max 200.0)
	    (neckwidth_min 8.0)
	    (width_max 0.0)
	    (width_min 15.0)
	)
	unless(member(cset axlCnsList('physical))
		when(axlCNSCreate('physical cset nil)
			axlUIWPrint(nil "Create Physical Constraint  - %s" cset)
		)
	)
	case(cset
		("DEFAULT"
			axlCNSMapClear()
			axlUIWPrint(nil "Import Physical Constraint  - \"DEFAULT\"")
			when(axlCNSSetPhysical("" nil Default nil)
				axlUIWPrint(nil "Import Complet...")
			)
			axlCNSMapUpdate()
		)
		("BGA-1.0MM"
			axlCNSMapClear()
			axlUIWPrint(nil "Import Physical Constraint  - \"BGA-1.0MM\"")
			when(axlCNSSetPhysical("BGA-1.0MM" nil BGA1_0 nil)
				axlUIWPrint(nil "Import Complet...")
			)
			axlCNSMapUpdate()
		)
		("BGA-0.8MM"
			axlCNSMapClear()
			axlUIWPrint(nil "Import Physical Constraint  - \"BGA-0.8MM\"")
			when(axlCNSSetPhysical("BGA-0.8MM" nil BGA0_8 nil)
				axlUIWPrint(nil "Import Complet...")
			)
			axlCNSMapUpdate()
		)
		("POWER"
			axlCNSMapClear()
			axlUIWPrint(nil "Import Physical Constraint  - \"POWER\"")
			when(axlCNSSetPhysical("POWER" nil POWER nil)
				axlUIWPrint(nil "Import Complet...")
			)
			axlCNSMapUpdate()
		)
	);end case
);end let
);end defun

defun(CNSImportSpacing (cset)
let((DEFAULT_SURFACE DEFAULT_INNER BGA1_0_SURFACE BGA1_0_INNER BGA0_8_SURFACE BGA0_8_INNER s20MILS s15MILS)
	DEFAULT_SURFACE = '((shape_shape 10.0)
	    (bondpad_bondpad 8.0)
	    (bondpad_shape 8.0)
	    (bondpad_line 8.0)
	    (hole_via 8.0)
	    (hole_thrupin 12.0)
	    (hole_hole 12.0)
	    (hole_shape 15.0)
	    (hole_line 8.0)
	    (uvia_bondpad 8.0)
	    (uvia_testvia 10.0)
	    (uvia_uvia 8.0)
	    (uvia_bbvia 8.0)
	    (uvia_via 8.0)
	    (uvia_testpin 8.0)
	    (uvia_smdpin 8.0)
	    (uvia_thrupin 8.0)
	    (uvia_shape 8.0)
	    (uvia_line 8.0)
	    (bbvia_bondpad 8.0)
	    (bbvia_testvia 10.0)
	    (bbvia_bbvia 8.0)
	    (bbvia_via 8.0)
	    (bbvia_testpin 8.0)
	    (bbvia_smdpin 8.0)
	    (bbvia_thrupin 8.0)
	    (bbvia_shape 8.0)
	    (bbvia_line 8.0)
	    (via_bondpad 8.0)
	    (via_via 10.0)
	    (via_shape 10.0)
	    (via_line 6.0)
	    (testvia_bondpad 10.0)
	    (testvia_testvia 38.0)
	    (testvia_via 12.0)
	    (testvia_smdpin 12.0)
	    (testvia_thrupin 13.0)
	    (testvia_shape 15.0)
	    (testvia_line 8.0)
	    (testpin_bondpad 8.0)
	    (testpin_testvia 38.0)
	    (testpin_via 8.0)
	    (testpin_testpin 18.0)
	    (testpin_smdpin 14.0)
	    (testpin_thrupin 15.0)
	    (testpin_shape 12.0)
	    (testpin_line 8.0)
	    (smdpin_bondpad 8.0)
	    (smdpin_via 8.0)
	    (smdpin_smdpin 7.0)
	    (smdpin_shape 8.0)
	    (smdpin_line 8.0)
	    (thrupin_bondpad 8.0)
	    (thrupin_via 8.0)
	    (thrupin_smdpin 12.0)
	    (thrupin_thrupin 12.0)
	    (thrupin_shape 15.0)
	    (thrupin_line 8.0)
	    (line_shape 10.0)
	    (line_line 6.0)
	)
	DEFAULT_INNER = '((shape_shape 10.0)
	    (bondpad_bondpad 8.0)
	    (bondpad_shape 8.0)
	    (bondpad_line 8.0)
	    (hole_via 8.0)
	    (hole_thrupin 12.0)
	    (hole_hole 12.0)
	    (hole_shape 15.0)
	    (hole_line 5.0)
	    (uvia_bondpad 8.0)
	    (uvia_testvia 10.0)
	    (uvia_uvia 8.0)
	    (uvia_bbvia 8.0)
	    (uvia_via 8.0)
	    (uvia_testpin 8.0)
	    (uvia_smdpin 8.0)
	    (uvia_thrupin 8.0)
	    (uvia_shape 8.0)
	    (uvia_line 8.0)
	    (bbvia_bondpad 8.0)
	    (bbvia_testvia 10.0)
	    (bbvia_bbvia 8.0)
	    (bbvia_via 8.0)
	    (bbvia_testpin 8.0)
	    (bbvia_smdpin 8.0)
	    (bbvia_thrupin 8.0)
	    (bbvia_shape 8.0)
	    (bbvia_line 8.0)
	    (via_bondpad 8.0)
	    (via_via 10.0)
	    (via_shape 10.0)
	    (via_line 6.0)
	    (testvia_bondpad 10.0)
	    (testvia_testvia 8.0)
	    (testvia_via 8.0)
	    (testvia_smdpin 8.0)
	    (testvia_thrupin 13.0)
	    (testvia_shape 15.0)
	    (testvia_line 6.0)
	    (testpin_bondpad 8.0)
	    (testpin_testvia 7.0)
	    (testpin_via 7.0)
	    (testpin_testpin 18.0)
	    (testpin_smdpin 14.0)
	    (testpin_thrupin 15.0)
	    (testpin_shape 10.0)
	    (testpin_line 8.0)
	    (smdpin_bondpad 8.0)
	    (smdpin_via 8.0)
	    (smdpin_smdpin 7.0)
	    (smdpin_shape 8.0)
	    (smdpin_line 8.0)
	    (thrupin_bondpad 8.0)
	    (thrupin_via 8.0)
	    (thrupin_smdpin 12.0)
	    (thrupin_thrupin 12.0)
	    (thrupin_shape 15.0)
	    (thrupin_line 5.0)
	    (line_shape 10.0)
	    (line_line 5.0)
	)
	BGA1_0_SURFACE = '((bbvia_gap 5.0)
	    (shape_shape 10.0)
	    (bondpad_bondpad 8.0)
	    (bondpad_shape 8.0)
	    (bondpad_line 8.0)
	    (hole_via 8.0)
	    (hole_thrupin 15.0)
	    (hole_hole 15.0)
	    (hole_shape 8.0)
	    (hole_line 7.0)
	    (uvia_bondpad 8.0)
	    (uvia_testvia 8.0)
	    (uvia_uvia 8.0)
	    (uvia_bbvia 8.0)
	    (uvia_via 8.0)
	    (uvia_testpin 8.0)
	    (uvia_smdpin 8.0)
	    (uvia_thrupin 8.0)
	    (uvia_shape 8.0)
	    (uvia_line 8.0)
	    (bbvia_bondpad 8.0)
	    (bbvia_testvia 8.0)
	    (bbvia_bbvia 8.0)
	    (bbvia_via 8.0)
	    (bbvia_testpin 8.0)
	    (bbvia_smdpin 8.0)
	    (bbvia_thrupin 8.0)
	    (bbvia_shape 8.0)
	    (bbvia_line 8.0)
	    (via_bondpad 8.0)
	    (via_via 8.0)
	    (via_shape 6.0)
	    (via_line 5.0)
	    (testvia_bondpad 8.0)
	    (testvia_testvia 8.0)
	    (testvia_via 8.0)
	    (testvia_smdpin 6.0)
	    (testvia_thrupin 13.0)
	    (testvia_shape 8.0)
	    (testvia_line 5.0)
	    (testpin_bondpad 8.0)
	    (testpin_testvia 8.0)
	    (testpin_via 8.0)
	    (testpin_testpin 18.0)
	    (testpin_smdpin 14.0)
	    (testpin_thrupin 15.0)
	    (testpin_shape 8.0)
	    (testpin_line 7.0)
	    (smdpin_bondpad 8.0)
	    (smdpin_via 6.0)
	    (smdpin_smdpin 7.0)
	    (smdpin_shape 8.0)
	    (smdpin_line 6.0)
	    (thrupin_bondpad 8.0)
	    (thrupin_via 8.0)
	    (thrupin_smdpin 14.0)
	    (thrupin_thrupin 15.0)
	    (thrupin_shape 8.0)
	    (thrupin_line 7.0)
	    (line_shape 8.0)
	    (line_line 6.0)
	)
	BGA1_0_INNER = '((shape_shape 10.0)
	    (bondpad_bondpad 8.0)
	    (bondpad_shape 8.0)
	    (bondpad_line 8.0)
	    (hole_via 8.0)
	    (hole_thrupin 15.0)
	    (hole_hole 15.0)
	    (hole_shape 6.0)
	    (hole_line 5.0)
	    (uvia_bondpad 8.0)
	    (uvia_testvia 8.0)
	    (uvia_uvia 8.0)
	    (uvia_bbvia 8.0)
	    (uvia_via 8.0)
	    (uvia_testpin 8.0)
	    (uvia_smdpin 8.0)
	    (uvia_thrupin 8.0)
	    (uvia_shape 8.0)
	    (uvia_line 8.0)
	    (bbvia_bondpad 8.0)
	    (bbvia_testvia 8.0)
	    (bbvia_bbvia 8.0)
	    (bbvia_via 8.0)
	    (bbvia_testpin 8.0)
	    (bbvia_smdpin 8.0)
	    (bbvia_thrupin 8.0)
	    (bbvia_shape 8.0)
	    (bbvia_line 8.0)
	    (via_bondpad 8.0)
	    (via_via 8.0)
	    (via_shape 6.0)
	    (via_line 5.0)
	    (testvia_bondpad 8.0)
	    (testvia_testvia 8.0)
	    (testvia_via 8.0)
	    (testvia_smdpin 6.0)
	    (testvia_thrupin 13.0)
	    (testvia_shape 6.0)
	    (testvia_line 5.0)
	    (testpin_bondpad 8.0)
	    (testpin_testvia 7.0)
	    (testpin_via 7.0)
	    (testpin_testpin 18.0)
	    (testpin_smdpin 14.0)
	    (testpin_thrupin 15.0)
	    (testpin_shape 8.0)
	    (testpin_line 6.0)
	    (smdpin_bondpad 8.0)
	    (smdpin_via 5.0)
	    (smdpin_smdpin 7.0)
	    (smdpin_shape 8.0)
	    (smdpin_line 6.0)
	    (thrupin_bondpad 8.0)
	    (thrupin_via 8.0)
	    (thrupin_smdpin 14.0)
	    (thrupin_thrupin 15.0)
	    (thrupin_shape 6.0)
	    (thrupin_line 5.0)
	    (line_shape 6.0)
	    (line_line 5.0)
	)
	BGA0_8_SURFACE = '((bbvia_gap 5.0)
	    (shape_shape 10.0)
	    (bondpad_bondpad 8.0)
	    (bondpad_shape 8.0)
	    (bondpad_line 8.0)
	    (hole_via 8.0)
	    (hole_thrupin 15.0)
	    (hole_hole 15.0)
	    (hole_shape 7.0)
	    (hole_line 7.0)
	    (uvia_bondpad 8.0)
	    (uvia_testvia 8.0)
	    (uvia_uvia 8.0)
	    (uvia_bbvia 8.0)
	    (uvia_via 8.0)
	    (uvia_testpin 8.0)
	    (uvia_smdpin 8.0)
	    (uvia_thrupin 8.0)
	    (uvia_shape 6.0)
	    (uvia_line 8.0)
	    (bbvia_bondpad 8.0)
	    (bbvia_testvia 8.0)
	    (bbvia_bbvia 8.0)
	    (bbvia_via 8.0)
	    (bbvia_testpin 8.0)
	    (bbvia_smdpin 8.0)
	    (bbvia_thrupin 8.0)
	    (bbvia_shape 6.0)
	    (bbvia_line 8.0)
	    (via_bondpad 8.0)
	    (via_via 8.0)
	    (via_shape 6.0)
	    (via_line 4.2)
	    (testvia_bondpad 8.0)
	    (testvia_testvia 8.0)
	    (testvia_via 8.0)
	    (testvia_smdpin 6.0)
	    (testvia_thrupin 13.0)
	    (testvia_shape 6.0)
	    (testvia_line 4.5)
	    (testpin_bondpad 8.0)
	    (testpin_testvia 8.0)
	    (testpin_via 8.0)
	    (testpin_testpin 18.0)
	    (testpin_smdpin 14.0)
	    (testpin_thrupin 15.0)
	    (testpin_shape 7.0)
	    (testpin_line 7.0)
	    (smdpin_bondpad 8.0)
	    (smdpin_via 4.2)
	    (smdpin_smdpin 7.0)
	    (smdpin_shape 7.0)
	    (smdpin_line 4.4)
	    (thrupin_bondpad 8.0)
	    (thrupin_via 8.0)
	    (thrupin_smdpin 14.0)
	    (thrupin_thrupin 15.0)
	    (thrupin_shape 7.0)
	    (thrupin_line 7.0)
	    (line_shape 6.0)
	    (line_line 5.0)
	)
	BGA0_8_INNER = '((shape_shape 10.0)
	    (bondpad_bondpad 8.0)
	    (bondpad_shape 8.0)
	    (bondpad_line 8.0)
	    (hole_via 8.0)
	    (hole_thrupin 15.0)
	    (hole_hole 15.0)
	    (hole_shape 6.0)
	    (hole_line 5.0)
	    (uvia_bondpad 8.0)
	    (uvia_testvia 8.0)
	    (uvia_uvia 8.0)
	    (uvia_bbvia 8.0)
	    (uvia_via 8.0)
	    (uvia_testpin 8.0)
	    (uvia_smdpin 8.0)
	    (uvia_thrupin 8.0)
	    (uvia_shape 6.0)
	    (uvia_line 8.0)
	    (bbvia_bondpad 8.0)
	    (bbvia_testvia 8.0)
	    (bbvia_bbvia 8.0)
	    (bbvia_via 8.0)
	    (bbvia_testpin 8.0)
	    (bbvia_smdpin 8.0)
	    (bbvia_thrupin 8.0)
	    (bbvia_shape 6.0)
	    (bbvia_line 8.0)
	    (via_bondpad 8.0)
	    (via_via 8.0)
	    (via_shape 6.0)
	    (via_line 4.2)
	    (testvia_bondpad 8.0)
	    (testvia_testvia 8.0)
	    (testvia_via 8.0)
	    (testvia_smdpin 6.0)
	    (testvia_thrupin 13.0)
	    (testvia_shape 6.0)
	    (testvia_line 4.5)
	    (testpin_bondpad 8.0)
	    (testpin_testvia 7.0)
	    (testpin_via 7.0)
	    (testpin_testpin 18.0)
	    (testpin_smdpin 14.0)
	    (testpin_thrupin 15.0)
	    (testpin_shape 6.0)
	    (testpin_line 5.5)
	    (smdpin_bondpad 8.0)
	    (smdpin_via 4.2)
	    (smdpin_smdpin 7.0)
	    (smdpin_shape 7.0)
	    (smdpin_line 4.4)
	    (thrupin_bondpad 8.0)
	    (thrupin_via 8.0)
	    (thrupin_smdpin 14.0)
	    (thrupin_thrupin 15.0)
	    (thrupin_shape 6.0)
	    (thrupin_line 5.0)
	    (line_shape 6.0)
	    (line_line 5.0)
	)
	s20MILS = '((bbvia_gap 5.0)
	    (shape_shape 10.0)
	    (bondpad_bondpad 8.0)
	    (bondpad_shape 8.0)
	    (bondpad_line 8.0)
	    (hole_via 8.0)
	    (hole_thrupin 12.0)
	    (hole_hole 12.0)
	    (hole_shape 15.0)
	    (hole_line 8.0)
	    (uvia_bondpad 8.0)
	    (uvia_testvia 10.0)
	    (uvia_uvia 8.0)
	    (uvia_bbvia 8.0)
	    (uvia_via 8.0)
	    (uvia_testpin 8.0)
	    (uvia_smdpin 8.0)
	    (uvia_thrupin 8.0)
	    (uvia_shape 8.0)
	    (uvia_line 8.0)
	    (bbvia_bondpad 8.0)
	    (bbvia_testvia 10.0)
	    (bbvia_bbvia 8.0)
	    (bbvia_via 8.0)
	    (bbvia_testpin 8.0)
	    (bbvia_smdpin 8.0)
	    (bbvia_thrupin 8.0)
	    (bbvia_shape 8.0)
	    (bbvia_line 8.0)
	    (via_bondpad 8.0)
	    (via_via 10.0)
	    (via_shape 10.0)
	    (via_line 6.0)
	    (testvia_bondpad 10.0)
	    (testvia_testvia 8.0)
	    (testvia_via 8.0)
	    (testvia_smdpin 8.0)
	    (testvia_thrupin 13.0)
	    (testvia_shape 15.0)
	    (testvia_line 8.0)
	    (testpin_bondpad 8.0)
	    (testpin_testvia 8.0)
	    (testpin_via 8.0)
	    (testpin_testpin 18.0)
	    (testpin_smdpin 14.0)
	    (testpin_thrupin 15.0)
	    (testpin_shape 10.0)
	    (testpin_line 8.0)
	    (smdpin_bondpad 8.0)
	    (smdpin_via 8.0)
	    (smdpin_smdpin 7.0)
	    (smdpin_shape 8.0)
	    (smdpin_line 8.0)
	    (thrupin_bondpad 8.0)
	    (thrupin_via 8.0)
	    (thrupin_smdpin 12.0)
	    (thrupin_thrupin 12.0)
	    (thrupin_shape 15.0)
	    (thrupin_line 8.0)
	    (line_shape 10.0)
	    (line_line 20.0)
	)
	s15MILS = '((bbvia_gap 5.0)
	    (shape_shape 10.0)
	    (bondpad_bondpad 8.0)
	    (bondpad_shape 8.0)
	    (bondpad_line 8.0)
	    (hole_via 8.0)
	    (hole_thrupin 12.0)
	    (hole_hole 12.0)
	    (hole_shape 15.0)
	    (hole_line 8.0)
	    (uvia_bondpad 8.0)
	    (uvia_testvia 10.0)
	    (uvia_uvia 8.0)
	    (uvia_bbvia 8.0)
	    (uvia_via 8.0)
	    (uvia_testpin 8.0)
	    (uvia_smdpin 8.0)
	    (uvia_thrupin 8.0)
	    (uvia_shape 8.0)
	    (uvia_line 8.0)
	    (bbvia_bondpad 8.0)
	    (bbvia_testvia 10.0)
	    (bbvia_bbvia 8.0)
	    (bbvia_via 8.0)
	    (bbvia_testpin 8.0)
	    (bbvia_smdpin 8.0)
	    (bbvia_thrupin 8.0)
	    (bbvia_shape 8.0)
	    (bbvia_line 8.0)
	    (via_bondpad 8.0)
	    (via_via 10.0)
	    (via_shape 10.0)
	    (via_line 6.0)
	    (testvia_bondpad 10.0)
	    (testvia_testvia 8.0)
	    (testvia_via 8.0)
	    (testvia_smdpin 8.0)
	    (testvia_thrupin 13.0)
	    (testvia_shape 15.0)
	    (testvia_line 8.0)
	    (testpin_bondpad 8.0)
	    (testpin_testvia 8.0)
	    (testpin_via 8.0)
	    (testpin_testpin 18.0)
	    (testpin_smdpin 14.0)
	    (testpin_thrupin 15.0)
	    (testpin_shape 10.0)
	    (testpin_line 8.0)
	    (smdpin_bondpad 8.0)
	    (smdpin_via 8.0)
	    (smdpin_smdpin 7.0)
	    (smdpin_shape 8.0)
	    (smdpin_line 8.0)
	    (thrupin_bondpad 8.0)
	    (thrupin_via 8.0)
	    (thrupin_smdpin 12.0)
	    (thrupin_thrupin 12.0)
	    (thrupin_shape 15.0)
	    (thrupin_line 8.0)
	    (line_shape 10.0)
	    (line_line 15.0)
	)
	unless(member(cset axlCnsList('spacing))
		when(axlCNSCreate('spacing cset nil)
			axlUIWPrint(nil "Create Spacing Constraint  - %s" cset)
		)
	)
	unless(member(cset axlCnsList('sameNet))
		axlCNSCreate('sameNet cset nil)
	)
	case(cset
		("DEFAULT"
			axlCNSMapClear()
			axlUIWPrint(nil "Import Spacing Constraint  - \"DEFAULT\"")
			foreach(layer axlGetParam("paramLayerGroup:ETCH")->groupMembers
			if(layer == "TOP" || layer == "BOTTOM"
			then
				axlCNSSetSpacing("" layer DEFAULT_SURFACE nil)
				axlCNSSetSameNet("" layer DEFAULT_SURFACE nil)
				;axlUIWPrint(nil "Import Complet...")
			else
				axlCNSSetSpacing("" layer DEFAULT_INNER nil)
				axlCNSSetSameNet("" layer DEFAULT_INNER nil)
			);end if
			);end foreach
			axlCNSMapUpdate()
			axlUIWPrint(nil "Import Complet...")
		)
		("BGA-1.0MM"
			axlCNSMapClear()
			axlUIWPrint(nil "Import Spacing Constraint  - \"BGA-1.0MM\"")
			;when(axlCNSSetSpacing("BGA-1.0MM" nil BGA1_0_SURFACE nil)
;				axlUIWPrint(nil "Import Complet...")
			;)
			foreach(layer axlGetParam("paramLayerGroup:ETCH")->groupMembers
			if(layer == "TOP" || layer == "BOTTOM"
			then
				axlCNSSetSpacing("BGA-1.0MM" layer BGA1_0_SURFACE nil)
				axlCNSSetSameNet("BGA-1.0MM" layer BGA1_0_SURFACE nil)
				;axlUIWPrint(nil "Import Complet...")
			else
				axlCNSSetSpacing("BGA-1.0MM" layer BGA1_0_INNER nil)
				axlCNSSetSameNet("BGA-1.0MM" layer BGA1_0_INNER nil)
			);end if
			);end foreach
			axlCNSMapUpdate()
			axlUIWPrint(nil "Import Complet...")
		)
		("BGA-0.8MM"
			axlCNSMapClear()
			axlUIWPrint(nil "Import Spacing Constraint  - \"BGA-0.8MM\"")
;			when(axlCNSSetSpacing("BGA-0.8MM" nil BGA0_8_SURFACE nil)
;				axlUIWPrint(nil "Import Complet...")
;			)
			foreach(layer axlGetParam("paramLayerGroup:ETCH")->groupMembers
			if(layer == "TOP" || layer == "BOTTOM"
			then
				axlCNSSetSpacing("BGA-0.8MM" layer BGA0_8_SURFACE nil)
				axlCNSSetSameNet("BGA-0.8MM" layer BGA0_8_SURFACE nil)
			else
				axlCNSSetSpacing("BGA-0.8MM" layer BGA0_8_INNER nil)
				axlCNSSetSameNet("BGA-0.8MM" layer BGA0_8_INNER nil)
			);end if
			);end foreach
			axlCNSMapUpdate()
			axlUIWPrint(nil "Import Complet...")
		)
		("20MILS"
			axlCNSMapClear()
			axlUIWPrint(nil "Import Spacing Constraint  - \"20MILS\"")
			when(axlCNSSetSpacing("20MILS" nil s20MILS nil)
				axlCNSSetSameNet("20MILS" nil s20MILS nil)
				axlUIWPrint(nil "Import Complet...")
			)
			axlCNSMapUpdate()
		)
		("15MILS"
			axlCNSMapClear()
			axlUIWPrint(nil "Import Spacing Constraint  - \"15MILS\"")
			when(axlCNSSetSpacing("15MILS" nil s15MILS nil)
				axlCNSSetSameNet("15MILS" nil s15MILS nil)
				axlUIWPrint(nil "Import Complet...")
			)
			axlCNSMapUpdate()
		)
	);end case
);end let
);end defun

defun(CNSImportForm (ver)
let((form)
	form = outfile("./cns_import.form")
	fprintf(form "FILE_TYPE=FORM_DEFN VERSION=2\n")
	fprintf(form "FORM\n")
	fprintf(form "FIXED\n")
	fprintf(form "PORT 40 20\n")
	fprintf(form "HEADER \"Constraint Import V%s\"\n" ver)
	fprintf(form "TILE\n\n")

	fprintf(form "TEXT \"Allegro\271\346\324\362\265\274\310\353\271\244\276\337 - By VivienLuo\" Ver\n" )
	fprintf(form "TLOC 1 1\n")
	fprintf(form "OPTIONS BOLD\n")
	fprintf(form "ENDTEXT\n")

	fprintf(form "GROUP \"Physical Constraint Import\"\n")
	fprintf(form "GLOC 1 3\n")
	fprintf(form "GSIZE 39 8\n")
	fprintf(form "ENDGROUP\n\n")

	fprintf(form "FIELD Default_P\n")
	fprintf(form "FLOC 3 6\n")
	fprintf(form "CHECKLIST \"Default\"\n")
	fprintf(form "ENDFIELD\n\n")

	fprintf(form "FIELD BGA1_0_P\n")
	fprintf(form "FLOC 15 6\n")
	fprintf(form "CHECKLIST \"BGA-1.0MM\"\n")
	fprintf(form "ENDFIELD\n\n")

	fprintf(form "FIELD BGA0_8_P\n")
	fprintf(form "FLOC 27 6\n")
	fprintf(form "CHECKLIST \"BGA-0.8MM\"\n")
	fprintf(form "ENDFIELD\n\n")

	fprintf(form "FIELD POWER\n")
	fprintf(form "FLOC 3 8\n")
	fprintf(form "CHECKLIST \"POWER \"\n")
	fprintf(form "ENDFIELD\n\n")

	fprintf(form "GROUP \"Spacing Constraint Import\"\n")
	fprintf(form "GLOC 1 11\n")
	fprintf(form "GSIZE 39 8\n")
	fprintf(form "ENDGROUP\n\n")

	fprintf(form "FIELD Default_S\n")
	fprintf(form "FLOC 3 14\n")
	fprintf(form "CHECKLIST \"Default\"\n")
	fprintf(form "ENDFIELD\n\n")

	fprintf(form "FIELD BGA1_0_S\n")
	fprintf(form "FLOC 15 14\n")
	fprintf(form "CHECKLIST \"BGA-1.0MM\"\n")
	fprintf(form "ENDFIELD\n\n")

	fprintf(form "FIELD BGA0_8_S\n")
	fprintf(form "FLOC 27 14\n")
	fprintf(form "CHECKLIST \"BGA-0.8MM\"\n")
	fprintf(form "ENDFIELD\n\n")

	fprintf(form "FIELD 20MILS\n")
	fprintf(form "FLOC 3 16\n")
	fprintf(form "CHECKLIST \"20MILS\"\n")
	fprintf(form "ENDFIELD\n\n")

	fprintf(form "FIELD 15MILS\n")
	fprintf(form "FLOC 15 16\n")
	fprintf(form "CHECKLIST \"15MILS\"\n")
	fprintf(form "ENDFIELD\n\n")

	fprintf(form "FIELD Import\n")
	fprintf(form "FLOC 3 20\n")
	fprintf(form "MENUBUTTON \"Import\" 6 3\n")
	fprintf(form "ENDFIELD\n")

	fprintf(form "FIELD Exit\n")
	fprintf(form "FLOC 17 20\n")
	fprintf(form "MENUBUTTON \"Exit\" 6 3\n")
	fprintf(form "ENDFIELD\n")

	fprintf(form "FIELD About\n")
	fprintf(form "FLOC 30 20\n")
	fprintf(form "MENUBUTTON \"Help\" 6 3\n")
	fprintf(form "ENDFIELD\n")

	fprintf(form "ENDTILE\n")
	fprintf(form "ENDFORM\n")
	close(form)
	;axlFormTest("./cmgr_import.form")
)
);end defun

defun(CNSImportHelp ()
let((filePort)
	filePort = outfile("./CnsImportHelp.txt")
	fprintf(filePort "\250x\250x\250x\250x\250x\250x\250x\250x\250x\250x\250x\250x\250x\250x\250x\250x\250x\250x\250x\250x\250x\250x\250x\n")
	fprintf(filePort "\250\207                                          \250\212 \n")
	fprintf(filePort "\250\207       \271\244\276\337\303\373\263\306\243\272CNS Import               \250\212 \n")
	fprintf(filePort "\250\207       \264\264\275\250\312\261\274\344\243\2722015\304\35211\324\30210\310\325           \250\212 \n")
	fprintf(filePort "\250\207   Cadence Skill\302\333\314\263 - allegro-skill.com  \250\212\n")
	fprintf(filePort "\250\207                                          \250\212 \n")
	fprintf(filePort "\250\211\250\211\250\211\250\211\250\211\250\211\250\211\250\211\250\211\250\211\250\211\250\211\250\211\250\211\250\211\250\211\250\211\250\211\250\211\250\211\250\211\250\211\250\211\n")
	fprintf(filePort "\271\246\304\334\313\265\303\367\243\272\n")
	fprintf(filePort "\270\303\320\241\271\244\276\337\326\367\322\252\323\303\300\264\265\274\310\353\263\243\271\346\265\304\322\273\320\251\271\346\324\362\243\254\261\334\303\342\312\326\266\257\320\336\270\304\265\274\326\302\265\304\322\273\320\251\n")
	fprintf(filePort "\264\355\316\363\241\243\n\n")
	fprintf(filePort "\312\271\323\303\313\265\303\367\243\272\n\n")
	fprintf(filePort "Physical Constraint Import\323\303\323\332\321\241\324\361\265\274\310\353\265\275Physical\265\304\271\346\324\362\241\243\304\254\n")
	fprintf(filePort "\310\317\321\241\324\361Default\272\315POWER\243\254\266\324\323\332\306\344\313\373\265\304\321\241\317\356\270\371\276\335\327\324\274\272\307\351\277\366\321\241\324\361\241\243\n\n")
	fprintf(filePort "Spacing Constraint Import\323\303\323\332\321\241\324\361\265\274\310\353\265\275Spacing\265\304\271\346\324\362\243\254\304\254\310\317\n")
	fprintf(filePort "\321\241\324\361Default\241\242BGA-1.0MM\241\242BGA-0.8MM\241\24215MILS\243\25420MIL\272\31515MIL\326\273\n")
	fprintf(filePort "\311\350\326\303\301\313Line to Line\265\304\271\346\324\362\243\254\306\344\323\340\262\316\312\375\323\353Default\322\273\326\302\241\243\322\362Allegro\n")
	fprintf(filePort "16\260\346\261\276\320\302\324\366\301\313Same Net\271\346\324\362\243\254\313\371\322\324\265\274\310\353Spacing\265\304\315\254\312\261\243\254\322\262\275\253Same \n")
	fprintf(filePort "Net\271\346\324\362\275\370\320\320\322\273\306\360\265\274\310\353\241\243\n\n")
	fprintf(filePort "                                                By VivienLuo\n")
	fprintf(filePort "                                                2015-11-14\n")
	close(filePort)
	axlUIViewFileCreate("./CnsImportHelp.txt" "CNS Import V1.3 - Help" t)
)
);end defun
